;;; ============================================================================
;;; APT_SymbolCheck.il  --  工具② 符号/封装一致性检查   【占位, 待实现】
;;; 阶段: 10_library (封装)      子菜单: 符号封装一致性
;;; ----------------------------------------------------------------------------
;;; 要解决的问题
;;;   其他软件(嘉立创/AD)转换过来的原理图符号常常不规范, 而 Allegro 要求
;;;   "封装引脚 ? 原理图符号引脚" 一一对应。转换件常见毛病:
;;;     * 符号少引脚   (符号只画了用到的脚, 封装上却有全部焊盘)
;;;     * 引脚编号对不上 (符号用 A1/B1, 封装用 1/2; 或顺序反了)
;;;     * 引脚名称与封装引脚对应不上
;;;
;;; 已确认的设计前提
;;;   * 权威 = 封装。冲突时以封装为准去修符号, 不是反过来。
;;;   * 第一版只做"检查 + 报告", 不做任何自动修改。
;;;
;;; 实现前还需明确(见 README/对话记录)
;;;   * "符号"的载体: device 文件 / OrCAD Capture 的 .OLB / 板内 compdef
;;;   * 检查项与报告格式
;;; ============================================================================

(defvar apt_symcheck_submenu "符号封装一致性")

;;; ---------------------------------------------------------------------------
;;; 占位命令: 只说清楚将来要做什么, 不做任何实际动作
;;; ---------------------------------------------------------------------------
(procedure (apt_cmd_symcheck)
    (axlUIConfirm (strcat
        "APTools  【符号封装一致性检查】—— 占位命令, 尚未实现。\n\n"
        "将来检查:\n"
        "  · 符号少引脚    (封装有、符号没有)\n"
        "  · 符号多引脚    (符号有、封装没有)\n"
        "  · 引脚编号对不上\n"
        "  · 引脚名称对不上\n\n"
        "原则: 以封装为准; 第一版只出报告, 不自动修改。")))

(axlCmdRegister "apt_symcheck" 'apt_cmd_symcheck ?cmdType "general")

;;; ---------------------------------------------------------------------------
;;; 菜单自声明 (阶段 = tools/10_library, 子菜单 = 符号封装一致性)
;;; ---------------------------------------------------------------------------
(apt_menuSub "10_library" apt_symcheck_submenu "检查符号与封装一致性" "apt_symcheck")

(printf "[APTools] APT_SymbolCheck 已加载 (占位, 待实现)\n")
